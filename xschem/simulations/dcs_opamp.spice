** sch_path: /home/tulpar/vlsi/work/analog/LVDS/xschem/tx/dcs_opamp
**.subckt dcs_opamp
XM5 net1 vnmos vss vss sg13_lv_nmos w=10u l=0.5u ng=50
XM6 von vpmos vdd vdd sg13_lv_pmos w=15u l=0.5u ng=58
XM1 vop vpmos vdd vdd sg13_lv_pmos w=15u l=0.5u ng=58
XM2 von vip net1 vss sg13_lv_nmos w=5.5u l=0.13u ng=8
XM3 vop vin net1 vss sg13_lv_nmos w=5.5u l=0.13u ng=8
XM4 vnmos vnmos vss vss sg13_lv_nmos w=7u l=0.5u ng=2
I0 vdd vnmos 100u
XM7 vpmos vpmos vdd vdd sg13_lv_pmos w=5u l=0.5u ng=5
I1 vpmos vss 100u
V1 vss 0 0
V2 vdd vss 1.2
V3 vip vss 0.6
V4 vin vss 0.6
**** begin user architecture code

.lib /home/tulpar/vlsi/pdk/ihp-sg13g2/libs.tech/ngspice/models/cornerMOSlv.lib mos_tt

.param temp=27
.control
op
.endc

**** end user architecture code
**.ends
.end
